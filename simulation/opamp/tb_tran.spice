Test OpAmp Tran

* Transient testbench for slew rate and settling time.
* Adapted from AnalogGym Amplifier/amp_spice_testbench/TB_Amplifier_Tran.cir with the
* conventions of the op-amp dataset used for the AnalogGym tasks:
*   - t_rise / t_fall are kept in seconds, so sr_rise / sr_fall are in V/s;
*   - tran.dat stores v(vout3) and v(visr), which circuits/opamp.py uses to extract the
*     settling time (1% band, maximum of the rising and falling edges).
* One change from the original: the falling-edge crossing is searched only after the
* falling input step (td), so ringing on the rising edge cannot give a negative t_fall.
* The amplifier is a unity-gain follower driven by a 0.3 V -> 0.5 V step at 1 us.
* Note: ngspice-47 prints the .meas results once and then reports the param= lines as
* "failed" on a second pass; the parser uses the first (valid) value.

.include ./myopamp.txt
.include ./var.spice
.param mc_mm_switch=0
.param mc_pr_switch=0
.include @SKY130_PDK_ROOT@/libs.tech/ngspice/corners/tt.spice
.include @SKY130_PDK_ROOT@/libs.tech/ngspice/r+c/res_typical__cap_typical.spice
.include @SKY130_PDK_ROOT@/libs.tech/ngspice/r+c/res_typical__cap_typical__lin.spice
.include @SKY130_PDK_ROOT@/libs.tech/ngspice/corners/tt/specialized_cells.spice

.PARAM supply_voltage = 1.8
.PARAM PARAM_CLOAD = @CLOAD@
.PARAM val0 = 3.000000e-01
.PARAM val1 = 5.000000e-01
.PARAM GBW_ideal = 5e4
.PARAM STEP_TIME = '10/GBW_ideal'

V1 vdd 0 'supply_voltage'
V2 vss 0 0

* XOP gnda vdda vinn vinp vout
VVISR visr 0 pulse('val0' 'val1' 1u 1p 1p '1*STEP_TIME' 1)
xop6 vss vdd vout3 visr vout3 op_amp
CLoad6 vout3 0 'PARAM_CLOAD'

.meas tran t_rise_edge when v(vout3)=0.4 rise=1
.meas tran t_rise param='t_rise_edge-1u'
.meas tran sr_rise param='0.1/t_rise'

.meas tran t_fall_edge when v(vout3)=0.4 fall=1 td='1u+STEP_TIME'
.meas tran t_fall param='t_fall_edge-1u-STEP_TIME'
.meas tran sr_fall param='0.1/t_fall'

.control
set filetype=ascii
tran 1u 4.01e-4
write tran.dat v(vout3) v(visr)
.endc

.end
